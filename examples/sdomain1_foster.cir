* Vector Fitting — Foster-I RLC Subcircuit
* Generated by vfit/export/spice_export.py
* Poles: 2   RMS error: 1.898e-16

.SUBCKT SDOMAIN1_FOSTER 1 0

* Branch 0: series inductance (e-term)
L0000   1  n0000  3.0814e-21

* Branch 1: series resistance (d-term)
R0000   n0000  n0001  0

* Branch 2: parallel RC  pole=-3.0000e+00+1.4600e-15j
* Z = R/(1+sRC),  R=500m,  C=666.7m
R0001  n0001 n0002  500m
C0000  n0001 n0002  666.7m

* Branch 3: shunt capacitance (near-DC pole)
C0001   n0002  0  2

.ENDS SDOMAIN1_FOSTER
