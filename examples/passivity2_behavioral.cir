* Vector Fitting — Behavioral Laplace Subcircuit (LTspice)
* Generated by vfit/export/spice_export.py
* Poles: 4   RMS error: 3.459e-01

.SUBCKT PASSIVITY2_LAPLACE in out 0
* V(out,0) = H(s) * V(in,0)
* H(s) = NUM(s) / DEN(s)
E1 out 0 LAPLACE {V(in,0)} = {(-2.029325e+35+-2.819556e+26*s+3.722567e+19*s**2+1.471550e+11*s**3+2.950959e-03*s**4)/(-3.135901e+34+2.083647e+26*s+2.045494e+18*s**2+3.586115e+08*s**3+1.000000e+00*s**4)}
Rbleed out 0 1G   ; DC path — prevents floating node warning

.ENDS PASSIVITY2_LAPLACE
