* Vector Fitting — Foster-I RLC Subcircuit
* Generated by vfit/export/spice_export.py
* Poles: 2   RMS error: 8.924e-02

.SUBCKT NOISY1_FOSTER 1 0

* Branch 0: series inductance (e-term)
L0000   1  n0000  333.6n

* Branch 1: series resistance (d-term)
R0000   n0000  n0001  0

* Branch 2: shunt capacitance (near-DC pole)
C0000   n0001  n0002  24.04K

* Branch 3: parallel RLC  pole=-2.7727e-01+1.6201e+00j
* Z = 1/(1/R + 1/sL + sC),  R=250.2m,  L=51.36m,  C=7.208
R0001  n0002 0  250.2m
L0001  n0002 0  51.36m
C0001  n0002 0  7.208

.ENDS NOISY1_FOSTER
