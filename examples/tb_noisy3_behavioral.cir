* LTspice test circuit for Behavioral Laplace subcircuit
* Generated by vfit/export/spice_export.py
* Run simulation and plot V(out) in Bode format to see H(s)

.include noisy3_behavioral.cir

* Input voltage source (1V AC)
Vin in 0 AC 1

* Instantiate the subcircuit
X1 in out 0 NOISY3_LAPLACE

* AC sweep: 100 points per decade from 1 MHz to 10 GHz
.ac dec 100 0.1  100

* Plot V(out) to see H(s) = Z(s)
.probe V(out)

.end
