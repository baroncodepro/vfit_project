* Vector Fitting — Foster-I RLC Subcircuit
* Generated by vfit/export/spice_export.py
* Poles: 4   RMS error: 4.097e-02

.SUBCKT INDUCTOR_MODEL 1 0

* Branch 0: series inductance (e-term)
L0000   1  n0000  7.023p

* Branch 1: series resistance (d-term)
R0000   n0000  n0001  397.4m

* Branch 2: parallel RLC  pole=-8.9395e+06+8.4207e+09j
* Z = 1/(1/R + 1/sL + sC),  R=186.4K,  L=46.99n,  C=300.1f
R0001  n0001 n0002  186.4K
L0001  n0001 n0002  46.99n
C0000  n0001 n0002  300.1f

* Branch 3: parallel RLC  pole=-9.6118e+04+6.3835e+07j
* Z = 1/(1/R + 1/sL + sC),  R=161.9m,  L=7.637p,  C=32.13u
R0002  n0002 n0003  161.9m
L0002  n0002 n0003  7.637p
C0001  n0002 n0003  32.13u

* Branch 4: parallel RLC  pole=-7.1745e+04+1.7951e+08j
* Z = 1/(1/R + 1/sL + sC),  R=587.2m,  L=2.615p,  C=11.87u
R0003  n0003 0  587.2m
L0003  n0003 0  2.615p
C0002  n0003 0  11.87u

.ENDS INDUCTOR_MODEL
