* Vector Fitting — Behavioral Laplace Subcircuit (LTspice)
* Generated by vfit/export/spice_export.py
* Poles: 8   RMS error: 1.430e+00

.SUBCKT PASSIVITY3_LAPLACE in out 0
* V(out,0) = H(s) * V(in,0)
* H(s) = NUM(s) / DEN(s)
E1 out 0 LAPLACE {V(in,0)} = {(-6.731836e+69+7.885784e+61*s+9.183033e+55*s**2+1.208982e+48*s**3+-1.538278e+39*s**4+-1.178837e+31*s**5+2.625782e+19*s**6+1.452334e+11*s**7+1.883779e-01*s**8)/(-9.441855e+68+1.172164e+61*s+1.264644e+55*s**2+-3.184872e+45*s**3+-1.172846e+38*s**4+-1.817677e+28*s**5+-9.315155e+19*s**6+4.109600e+08*s**7+1.000000e+00*s**8)}
Rbleed out 0 1G   ; DC path — prevents floating node warning

.ENDS PASSIVITY3_LAPLACE
