* Vector Fitting — Behavioral Laplace Subcircuit (LTspice)
* Generated by vfit/export/spice_export.py
* Poles: 6   RMS error: 3.019e-03
* Normalization: w0 = 2.570465e+09 rad/s  (sn = s/w0 is order-1 across band)

.SUBCKT FILTER_LAPLACE in out 0
* V(out,0) = H(s) * V(in,0)
* H(s) = NUM(sn) / DEN(sn),  sn = s / w0
E1 out 0 LAPLACE {V(in,0)} = {(6.835597e+55+2.472881e+56*(s/2.570465e+09)+-4.383110e+56*(s/2.570465e+09)**2+-7.907714e+56*(s/2.570465e+09)**3+6.146582e+55*(s/2.570465e+09)**4+1.204802e+55*(s/2.570465e+09)**5+-5.399501e+54*(s/2.570465e+09)**6)/(1.398549e+56+1.569937e+56*(s/2.570465e+09)+-1.571466e+57*(s/2.570465e+09)**2+-5.038090e+57*(s/2.570465e+09)**3+-3.717704e+57*(s/2.570465e+09)**4+4.874182e+56*(s/2.570465e+09)**5+2.884498e+56*(s/2.570465e+09)**6)}
Rbleed out 0 1G   ; DC path — prevents floating node warning

.ENDS FILTER_LAPLACE
