* Vector Fitting — Foster-I RLC Subcircuit
* Generated by vfit/export/spice_export.py
* Poles: 8   RMS error: 1.430e+00

.SUBCKT PASSIVITY3_FOSTER 1 0

* Branch 0: series inductance (e-term)
L0000   1  n0000  8.909p

* Branch 1: series resistance (d-term)
R0000   n0000  n0001  188.4m

* Branch 2: parallel RLC  pole=-4.1573e+07+1.8763e+10j
* Z = 1/(1/R + 1/sL + sC),  R=935.6m,  L=221f,  C=12.86n
R0001  n0001 n0002  935.6m
L0001  n0001 n0002  221f
C0000  n0001 n0002  12.86n

* Branch 3: parallel RLC  pole=-2.3625e+08+3.7656e+09j
* Z = 1/(1/R + 1/sL + sC),  R=150.1,  L=4.983n,  C=14.1p
R0002  n0002 n0003  150.1
L0002  n0002 n0003  4.983n
C0001  n0002 n0003  14.1p

* Branch 4: parallel RLC  pole=-3.0815e+06+1.1232e+09j
* Z = 1/(1/R + 1/sL + sC),  R=2.372,  L=11.59p,  C=68.4n
R0003  n0003 n0004  2.372
L0003  n0003 n0004  11.59p
C0002  n0003 n0004  68.4n

* Branch 5: parallel RLC  pole=-4.7197e+07+9.4134e+08j
* Z = 1/(1/R + 1/sL + sC),  R=942.8,  L=100.2n,  C=11.24p
R0004  n0004 n0005  942.8
L0004  n0004 n0005  100.2n
C0003  n0004 n0005  11.24p

* Branch 6: parallel RLC  pole=-3.9969e+05+1.2238e+08j
* Z = 1/(1/R + 1/sL + sC),  R=5.741,  L=306.4p,  C=217.9n
R0005  n0005 n0006  5.741
L0005  n0005 n0006  306.4p
C0004  n0005 n0006  217.9n

* Branch 7: parallel RLC  pole=-6.8595e+04+1.3593e+07j
* Z = 1/(1/R + 1/sL + sC),  R=1.022,  L=759.1p,  C=7.13u
R0006  n0006 n0007  1.022
L0006  n0006 n0007  759.1p
C0005  n0006 n0007  7.13u

* Branch 8: parallel RLC  pole=-3.6135e+03+6.5608e+06j
* Z = 1/(1/R + 1/sL + sC),  R=195.2,  L=32.77n,  C=708.9n
R0007  n0007 0  195.2
L0007  n0007 0  32.77n
C0006  n0007 0  708.9n

.ENDS PASSIVITY3_FOSTER
