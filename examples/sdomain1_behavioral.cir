* Vector Fitting — Behavioral Laplace Subcircuit (LTspice)
* Generated by vfit/export/spice_export.py
* Poles: 2   RMS error: 1.898e-16

.SUBCKT SDOMAIN1_LAPLACE in out 0
* V(out,0) = H(s) * V(in,0)
* H(s) = NUM(s) / DEN(s)
E1 out 0 LAPLACE {V(in,0)} = {(-8.881784e-16+1.000000e+00*s+-1.949539e-18*s**2)/(3.000000e+00+4.000000e+00*s+1.000000e+00*s**2)}
Rbleed out 0 1G   ; DC path — prevents floating node warning

.ENDS SDOMAIN1_LAPLACE
