* LTspice test circuit for Behavioral Laplace subcircuit
* Generated by vfit/export/spice_export.py
* Run simulation and plot V(out) in Bode format to see H(s)

.include multi_peak_from_csv_behavioral.cir

* Input voltage source (1V AC)
Vin in 0 AC 1

* Instantiate the subcircuit
X1 in out 0 MP_LAPLACE

* AC sweep: 100 points per decade from 5K to 2Meg
.ac dec 100 5K 2Meg

.end
