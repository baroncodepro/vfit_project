* Vector Fitting — Foster-I RLC Subcircuit
* Generated by vfit/export/spice_export.py
* Poles: 2   RMS error: 2.296e-14

.SUBCKT SDOMAIN2_FOSTER 1 0

* Branch 0: series inductance (e-term)
L0000   1  n0000  5.9807e-19

* Branch 1: series resistance (d-term)
R0000   n0000  n0001  9.8547e-16

* Branch 2: parallel RLC  pole=-2.0000e-01+1.9900e+00j
* Z = 1/(1/R + 1/sL + sC),  R=5,  L=500m,  C=500m
R0001  n0001 0  5
L0001  n0001 0  500m
C0000  n0001 0  500m

.ENDS SDOMAIN2_FOSTER
