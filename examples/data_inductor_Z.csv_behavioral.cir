* Vector Fitting ¡X Behavioral Laplace Subcircuit
* Generated by vfit/export/spice_export.py
* Poles: 6   RMS error: 1.457e-01

.SUBCKT DATA_INDUCTOR_Z.CSV_BEH 1 0
* Laplace transfer function: H(s) = NUM(s)/DEN(s)
* NUM coefficients (a0, a1, a2, ...): 6.531928e+52 4.367481e+44 -3.746389e+37 -2.539148e+29 4.951538e+20 3.342327e+12 3.778123e+00
* DEN coefficients (b0, b1, b2, ...): 9.223706e+51 2.460981e+42 -5.273426e+36 -3.580543e+26 6.937294e+19 1.373050e+08 1.000000e+00

* HSPICE syntax:
Vout_probe 1 0 DC 0
B_laplace 1 0 V = {laplace(v(1,0))={
+ numer=[6.531928e+52 4.367481e+44 -3.746389e+37 -2.539148e+29 4.951538e+20 3.342327e+12 3.778123e+00]
+ denom=[9.223706e+51 2.460981e+42 -5.273426e+36 -3.580543e+26 6.937294e+19 1.373050e+08 1.000000e+00]}}

.ENDS DATA_INDUCTOR_Z.CSV_BEH

* ---- LTspice equivalent ----
* .param s={2*pi*i*frequency}
* B1 out 0 V = ((6.5319e+52 + 4.3675e+44*s + -3.7464e+37*s**2 + -2.5391e+29*s**3 + 4.9515e+20*s**4 + 3.3423e+12*s**5 + 3.7781e+00*s**6)/(9.2237e+51 + 2.4610e+42*s + -5.2734e+36*s**2 + -3.5805e+26*s**3 + 6.9373e+19*s**4 + 1.3730e+08*s**5 + 1.0000e+00*s**6))
