* Vector Fitting — Behavioral Laplace Subcircuit (LTspice)
* Generated by vfit/export/spice_export.py
* Poles: 10   RMS error: 7.306e-05
* Normalization: w0 = 3.914620e+05 rad/s  (sn = s/w0 is order-1 across band)

.SUBCKT MP_LAPLACE in out 0
* V(out,0) = H(s) * V(in,0)
* H(s) = NUM(sn) / DEN(sn),  sn = s / w0
E1 out 0 LAPLACE {V(in,0)} = {(-3.224353e+59+-4.534455e+60*(s/3.914620e+05)+-6.473002e+59*(s/3.914620e+05)**2+6.456245e+59*(s/3.914620e+05)**3+7.125624e+60*(s/3.914620e+05)**4+2.125904e+61*(s/3.914620e+05)**5+4.309725e+60*(s/3.914620e+05)**6+5.223005e+60*(s/3.914620e+05)**7+1.911424e+59*(s/3.914620e+05)**8+1.053203e+59*(s/3.914620e+05)**9+-8.000233e+52*(s/3.914620e+05)**10)/(-1.815934e+58+-6.416506e+57*(s/3.914620e+05)+-4.736830e+58*(s/3.914620e+05)**2+1.338466e+58*(s/3.914620e+05)**3+1.396436e+59*(s/3.914620e+05)**4+5.389757e+58*(s/3.914620e+05)**5+1.403110e+59*(s/3.914620e+05)**6+1.002933e+58*(s/3.914620e+05)**7+1.020844e+58*(s/3.914620e+05)**8+1.931760e+56*(s/3.914620e+05)**9+8.450771e+55*(s/3.914620e+05)**10)}
Rbleed out 0 1G   ; DC path — prevents floating node warning

.ENDS MP_LAPLACE
