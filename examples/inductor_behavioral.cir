* Vector Fitting — Behavioral Laplace Subcircuit (LTspice)
* Generated by vfit/export/spice_export.py
* Poles: 4   RMS error: 4.097e-02
* Normalization: w0 = 7.331704e+08 rad/s  (sn = s/w0 is order-1 across band)

.SUBCKT INDUCTOR_LAPLACE in out 0
* V(out,0) = H(s) * V(in,0)
* H(s) = NUM(sn) / DEN(sn),  sn = s / w0
E1 out 0 LAPLACE {V(in,0)} = {(-9.549860e+35+-2.801027e+37*(s/7.331704e+08)+4.509507e+37*(s/7.331704e+08)**2+1.312841e+39*(s/7.331704e+08)**3+1.148367e+35*(s/7.331704e+08)**4)/(-8.122627e+35+-1.445551e+34*(s/7.331704e+08)+3.809559e+37*(s/7.331704e+08)**2+1.311854e+34*(s/7.331704e+08)**3+2.889481e+35*(s/7.331704e+08)**4)}
Rbleed out 0 1G   ; DC path — prevents floating node warning

.ENDS INDUCTOR_LAPLACE
