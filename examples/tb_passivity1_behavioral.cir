* LTspice test circuit for Behavioral Laplace subcircuit
* Generated by vfit/export/spice_export.py
* Run simulation and plot V(out) in Bode format to see H(s)

.include passivity1_behavioral.cir

* Input voltage source (1V AC)
Vin in 0 AC 1

* Instantiate the subcircuit
X1 in out 0 PASSIVITY1_LAPLACE

* AC sweep: 100 points per decade from 1 MHz to 10 GHz
.ac dec 100 1Meg 10000Meg

.end
