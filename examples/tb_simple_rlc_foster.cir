* LTspice test circuit for Foster RLC subcircuit
* Generated by vfit/export/spice_export.py
* Run simulation and plot V(1) in Bode format to see impedance Z(s)

.include simple_rlc_foster.cir

* Voltage source: 1V AC at node 1
Vin  1 0 AC 1

* Instantiate the subcircuit (port_pos=1, port_neg=0)
X1 1 0 SIMPLE_RLC_FOSTER

* AC sweep: 100 points per decade from 1Meg to 10G
.ac dec 100 1Meg 10G

.end
