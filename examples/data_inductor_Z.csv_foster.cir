* Vector Fitting ¡X Foster-I RLC Subcircuit
* Generated by vfit/export/spice_export.py
* Poles: 6   RMS error: 1.457e-01

.SUBCKT DATA_INDUCTOR_Z.CSV_FOSTER 1 0

* Branch 0: series inductance (e-term)
L0000   1  0  939.9p

* Branch 1: series resistance (d-term)
R0000   1  0  3.778

* Branch 2: parallel RLC  pole=-1.4506e+07+8.4304e+09j
* Z = 1/(1/R + 1/sL + sC),  R=116.5K,  L=47.54n,  C=296f
R0001  1 0  116.5K
L0001  1 0  47.54n
C0000  1 0  296f

* Branch 3: parallel RLC  pole=-1.3378e+05+6.3639e+07j
* Z = 1/(1/R + 1/sL + sC),  R=164.1m,  L=10.84p,  C=22.78u
R0002  1 0  164.1m
L0002  1 0  10.84p
C0001  1 0  22.78u

* Branch 4: parallel RLC  pole=-1.4636e+05+8.9161e+07j
* Z = 1/(1/R + 1/sL + sC),  R=57.74m,  L=2.126p,  C=59.17u
R0003  1 0  57.74m
L0003  1 0  2.126p
C0002  1 0  59.17u

* Branch 5: parallel RLC  pole=-1.9465e+05+1.6197e+08j
* Z = 1/(1/R + 1/sL + sC),  R=78.31m,  L=1.162p,  C=32.8u
R0004  1 0  78.31m
L0004  1 0  1.162p
C0003  1 0  32.8u

* Branch 6: parallel RLC  pole=-5.1604e+05+1.4432e+08j
* Z = 1/(1/R + 1/sL + sC),  R=35.41m,  L=1.755p,  C=27.36u
R0005  1 0  35.41m
L0005  1 0  1.755p
C0004  1 0  27.36u

.ENDS DATA_INDUCTOR_Z.CSV_FOSTER
